ADE simulation setup
Run mode: Single Run, Sweeps and Corners
Tests:
  DigitalLab_StartingLayout:Inverter_Lab5_TB_pPar:1: DigitalLab_StartingLayout/Inverter_Lab5_TB_pPar/schematic, simulator spectre
    Outputs: NML; NMH
Global variables:
  beta = 2:2:10
  C = 1p
  vdc = 0
  Vdd = 1.8
