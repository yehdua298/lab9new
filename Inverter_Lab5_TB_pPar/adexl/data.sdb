ADE simulation setup
Run mode: Single Run, Sweeps and Corners
Tests:
  DigitalLab_StartingLayout:Inverter_Lab5_TB_pPar:1: DigitalLab_StartingLayout/Inverter_Lab5_TB_pPar/schematic, simulator spectre
Global variables:
  beta = 2:2:10
  C = 1p
  Vdd = 1.8
  Vin_Delay = 1f (off)
  Vin_FT = 10p (off)
  Vin_High = Vdd (off)
  Vin_Low = 0 (off)
  Vin_Period = 100n (off)
  Vin_RT = 10p (off)
  W = 2 (off)
  W1 = 1
  vdc = 0
