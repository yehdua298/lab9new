ADE simulation setup
Run mode: Single Run, Sweeps and Corners
Tests:
  DigitalLab_StartingLayout:Inverter_Lab5_TB_pPar:1: DigitalLab_StartingLayout/Inverter_Lab5_TB_pPar/config, simulator spectre
    Outputs: TPD; Tphl; Tplh
Global variables:
  C = 1p
  Vdd = 1.8
  Vin_Delay = 0
  Vin_FT = 100p
  Vin_High = Vdd
  Vin_Low = 0
  Vin_Period = 100n
  Vin_RT = 100p
