ADE simulation setup
Run mode: Single Run, Sweeps and Corners
Tests:
  DigitalLab_StartingLayout:oscillatorTB:1: DigitalLab_StartingLayout/oscillatorTB/schematic, simulator spectre
Global variables:
  beta = 2
  VDD = 1.8
